`ifndef GPIO_CTRL_RDL_DEFINED
`define GPIO_CTRL_RDL_DEFINED

addrmap gpio_ctrl {

    desc = "GPIO Control CSR";

    ////////////////////////////////////////////////////////////////////////////
    // Register Definitions
    ////////////////////////////////////////////////////////////////////////////
    //---------------------------------

    reg CONTROL {
        regwidth = 32;
        accesswidth = 32;

        field {
            sw = rw;
            hw = r;
            desc = "Register-driven drive-strength.";
        } drive_strength[2:0] = 0x2;

        field {
            sw = rw;
            hw = r;
            desc = "Register-driven pull enable. Default is disabled";
        } pull_enable_n0_scan[7:7] = 0x0;

        field {
            sw = rw;
            hw = r;
            desc = "Register-driven pull select - by default we pull down";
        } pull_select[8:8] = 0x0;

        field {
            sw = rw;
            hw = r;
            desc = "Register-driven schmitt select.";
        } schmitt_select[10:10] = 0x0;

        field {
            sw = rw;
            hw = r;
            desc = "Setting this choosing the register values for PAD settings. This includes pull_enable, pull_select, and schmitt_select";
        } config_enable[15:15] = 0x0;

        field {
            sw = r;
            hw = w;
            desc = "When set, this bit indicates that the strap value is valid. This field is not set if the GPIO is not an input by default";
        } strap_valid[22:22] = 0x0;

        field {
            sw = r;
            hw = w;
            desc = "This register holds the captured value that was applied to the pad when reset was de-asserted.";
        } strap_value[23:23] = 0x0;

    };

    ////////////////////////////////////////////////////////////////////////////
    // Address Map
    ////////////////////////////////////////////////////////////////////////////

    CONTROL       CONTROL        @0x0;

};

`endif