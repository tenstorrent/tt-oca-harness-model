`ifndef SEP_LIFECYCLE_CTRL_RDL
`define SEP_LIFECYCLE_CTRL_RDL

addrmap sep_lifecycle_ctrl {
    
    reg FEAT_CTRL_LO {
        field {
            sw = r;
            hw = w;
            desc = "Lifecycle feature control bits, lower 32";
        } feature_control_lo [31:0] = 0x0;
    };
    
    reg FEAT_CTRL_HI {
        field {
            sw = r;
            hw = w;
            desc = "Lifecycle feature control bits, upper 32";
        } feature_control_hi [31:0] = 0x0;
    };

    reg FEAT_CTRL_UPPER {
        field {
            sw = r;
            hw = w;
            desc = "Upper 32 bits of lifecycle feature control bits";
        } feature_control [31:0] = 0x0;
    };


    reg DEMOTE {
        field {
            sw = rw;
            hw = r;
            swwe = true;
            onwrite = woset;
            desc = "Demote bit to enter PROD_DBG state";
        } demote [0:0] = 0x0;

        field {
            sw = rw;
            hw = r;
            onwrite = woset;
            desc = "Demote lock bit. Once locked, demote can no longer be changed";
        } lock [1:1] = 0x0;

        field {
            sw = rw;
            hw = r;
            onwrite = woset;
            desc = "Not used";
        } rsvd [31:2] = 0x0;
    };

    ////////////////////////////////////////////////////////////////////////////
    // Address Map
    ////////////////////////////////////////////////////////////////////////////

    FEAT_CTRL_LO    FEAT_CTRL_LO            @0x0000;
    FEAT_CTRL_HI    FEAT_CTRL_HI            @0x0004;

    DEMOTE                DEMOTE          @0x1000;

};

`endif